// Copyright lowRISC contributors.
// Licensed under the Apache License, Version 2.0, see LICENSE for details.
// SPDX-License-Identifier: Apache-2.0

// gf_mult reg 

{
    name: "gf_mult",
    clock_primary: "clk_i",
    reset_primary: "rst_ni",
    bus_interfaces:[ 
        {
             protocol: "reg_iface",
             direction: "device"
         }
      ],

    regwidth: "32",
    registers: [
        {
            name: "OP_A",
            desc: "Subword of Operand A.",
            swaccess: "wo",
            fields: [
                { bits: "7:0", name: "op_a", desc: "input parameter a"
                }
            ],
         
        },
        { 
            name: "OP_B",
            desc: "Subword of Operand B.",
            swaccess: "wo",
            fields: [
                { bits: "7:0", name: "op_b", desc: "input parameter b"
                }
            ],

        },
        { 
            name: "RESULT",
            desc: "results",
            swaccess: "ro",
            hwaccess: "hwo",
            hwext: "true",
            fields: [
                { bits: "7:0", name: "result", desc: "output"
                }
            ],
        },
        { name: "CTRL1",
          desc: "Controls trigger signal of the gf arithmetic.",
          swaccess: "wo",
          hwaccess: "hro",
          hwext: "true",
          hwqe : "true",
          fields: [
              { bits: "0", name: "TRIGGER", desc: "Trigger operation on rising edge."
              }
             
          ]
        },
        { name: "CTRL2",
          desc: "Controls trigger signal of the gf arithmetic.",
          swaccess: "wo",
          hwaccess: "hrw",
          hwext: "true",
          hwqe : "true",
          fields: [ 
              { bits: "0:0", name: "Op_Sel", desc: " Select the operation.",
         	enum: [
              		{ value: "0", name: "ADD", desc: "Perf ADD operation." },
              		{ value: "1", name: "MUL", desc: "Perf MUL operation." },
            	]
              }
          ]
        },
        { name: "STATUS",
          desc: "Contains the current status of the accelerator.",
          swaccess: "ro",
          hwaccess: "hwo",
          hwext: "true",
          fields: [ 
              { bits: "0:0", name: "Status", desc: " Select the operation.",
         	enum: [
              		{ value: "0", name: "IDLE",    desc: "IDLE Status."},
              		{ value: "1", name: "PENDING", desc: "Pending Stauts." },
            	]
              }
          ]
       },
    ],
}
