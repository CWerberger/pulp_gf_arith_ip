{
    name: "gf_mult",
    clock_primary: "clk_i",
    reset_primary: "rst_ni",
    bus_device: "reg",
    bus_host: "",

    regwidth: "32",
    registers: [
        {
            name: "OP_A",
            desc: "Subword of Operand A.",
            cname: "OP_A",
            swaccess: "wo",
            fields: [
                { bits: "7:0"
                }
            ],
         
        },
        { 
            name: "OP_B",
            desc: "Subword of Operand B.",
            cname: "OP_B",
            swaccess: "wo",
            fields: [
                { bits: "7:0"
                }
            ],

        },
        { 
            name: "RESULT",
            desc: "results",
            cname: "RESULT",
            swaccess: "ro",
            hwaccess: "hwo",
            hwext: "true",
            fields: [
                { bits: "7:0"
                }
            ],
        },
        { name: "CTRL1",
          desc: "Controls trigger signal of the gf arithmetic.",
          swaccess: "wo",
          hwaccess: "hro",
          hwext: "true",
          fields: [
              { bits: "0", name: "TRIGGER",
                desc: "Trigger operation on rising edge."
              }
             
          ]
        },
        { name: "CTRL2",
          desc: "Controls trigger signal of the gf arithmetic.",
          swaccess: "wo",
          hwaccess: "hrw",
          hwext: "true",
          fields: [
              { bits: "0", name: "ADD",
                desc: "Perf ADD operation."
              }
              { bits: "1", name: "MULT",
                desc: "Perf MULT operation."
              }
             
          ]
        },
        { name: "STATUS",
          desc: "Contains the current status of the accelerator.",
          swaccess: "ro",
          hwaccess: "hwo",
          hwext: "true",
          fields: [
          { bits: "0", name: "IDLE",
                desc: "IDLE Status."
              }
              { bits: "1", name: "PENDING",
                desc: "Pending Stauts."
              }
          ]
        }
    ],
}
